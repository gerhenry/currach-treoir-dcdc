* TR100 ERROR AMP V2 FIXED

**************************************************
* SUPPLY
**************************************************
VDD vdd 0 1.8

**************************************************
* INPUTS
**************************************************
VREF ref 0 0.6
VFB  fb  0 PWL(
+ 0      0.40
+ 20u    0.40
+ 40u    0.55
+ 60u    0.60
+ 80u    0.65
+ 100u   0.80
)

**************************************************
* ERROR AMP CORE
**************************************************
.param GM=100u

* Correct polarity for buck control
GERR 0 verr value = { GM*(V(ref)-V(fb)) }

**************************************************
* OUTPUT BIAS (centers around mid-rail)
**************************************************
RUP vdd verr 50k
RDN verr 0   50k

**************************************************
* OUTPUT RESISTANCE (stabilises node)
**************************************************
ROUT verr 0 50k

**************************************************
* COMPENSATION
**************************************************
CCOMP verr 0 20p

.control
set noaskquit
tran 100n 100u
wrdata ~/tmp/tr100_error_amp_v2_fix.dat v(ref) v(fb) v(verr)
.endc

.end
