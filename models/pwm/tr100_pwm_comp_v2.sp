* TR100 PWM COMPARATOR V2 (FIXED)

**************************************************
* SUPPLY
**************************************************
VDD vdd 0 1.8

**************************************************
* INPUTS
**************************************************
VERR verr 0 PWL(
+ 0      0.95
+ 20u    0.95
+ 40u    0.80
+ 60u    0.65
+ 80u    0.50
+ 100u   0.30
)

**************************************************
* RAMP GENERATOR (triangle via PULSE + RC)
**************************************************
VRAMP_SRC ramp_in 0 PULSE(0 1 0 1n 1n 0.5u 1u)

RRAMP ramp_in ramp 10k
CRAMP ramp 0 100p

**************************************************
* PWM COMPARATOR (soft)
**************************************************
BPWM pwm 0 V = { 0.9*(1+tanh((V(verr)-V(ramp))/0.02)) }

**************************************************
* LOAD
**************************************************
RLOAD pwm 0 100k
CLOAD pwm 0 1p

.control
set noaskquit
tran 10n 100u
wrdata ~/tmp/tr100_pwm_comp_v2.dat v(verr) v(ramp) v(pwm)
.endc

.end
